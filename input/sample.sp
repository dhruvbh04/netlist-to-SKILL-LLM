* test netlist

XM1 out in 0 0 nch W=1u L=180n
R1 vdd out 10k
C1 out 0 2p
